** sch_path: /foss/designs/sg13cmos5l_rodovalho_ip__dda/xschem/dda0_slice.sch
**.subckt dda0_slice ipa ima ipb imb o avdd avss vsub en enb ib bn yp ym
*.iopin avdd
*.iopin avss
*.iopin ipa
*.iopin ima
*.iopin o
*.iopin ib
*.iopin bn
*.iopin yp
*.iopin ym
*.iopin vsub
*.iopin en
*.iopin enb
*.iopin ipb
*.iopin imb
x10d[1] xna bn avss avss n1_4
x10d[0] xna bn avss avss n1_4
x11d[1] xna bn avss avss n1_4
x11d[0] xna bn avss avss n1_4
x10c[1] yp ima xna avss n1_4
x10c[0] yp ima xna avss n1_4
x11c[1] ym ipa xna avss n1_4
x11c[0] ym ipa xna avss n1_4
x12a[1] yp yp avdd avdd p1_4
x12a[0] yp yp avdd avdd p1_4
x01c[1] bn enb avss avss n1_1
x01c[0] bn enb avss avss n1_1
x01b[1] ib en bn avss n1_1
x01b[0] ib en bn avss n1_1
x00c[1] ib bn avss avss n1_4
x00c[0] ib bn avss avss n1_4
x1[1] yp ym avdd avdd p1_4
x1[0] yp ym avdd avdd p1_4
x2[1] ym ym avdd avdd p1_4
x2[0] ym ym avdd avdd p1_4
x3[1] ym yp avdd avdd p1_4
x3[0] ym yp avdd avdd p1_4
x4[1] xnb bn avss avss n1_4
x4[0] xnb bn avss avss n1_4
x5[1] xnb bn avss avss n1_4
x5[0] xnb bn avss avss n1_4
x6[1] yp ipb xnb avss n1_4
x6[0] yp ipb xnb avss n1_4
x7[1] ym ipb xnb avss n1_4
x7[0] ym ipb xnb avss n1_4
x8[3] z yp avdd avdd p1_4
x8[2] z yp avdd avdd p1_4
x8[1] z yp avdd avdd p1_4
x8[0] z yp avdd avdd p1_4
x9[3] o ym avdd avdd p4_1
x9[2] o ym avdd avdd p4_1
x9[1] o ym avdd avdd p4_1
x9[0] o ym avdd avdd p4_1
x10[3] z z avss avss n1_4
x10[2] z z avss avss n1_4
x10[1] z z avss avss n1_4
x10[0] z z avss avss n1_4
x11[3] o z avss avss n4_1
x11[2] o z avss avss n4_1
x11[1] o z avss avss n4_1
x11[0] o z avss avss n4_1
**.ends

* expanding   symbol:  n1_4.sym # of pins=4
** sym_path: /foss/designs/sg13cmos5l_rodovalho_ip__dda/xschem/n1_4.sym
** sch_path: /foss/designs/sg13cmos5l_rodovalho_ip__dda/xschem/n1_4.sch
.subckt n1_4 D G S B
*.iopin D
*.iopin G
*.iopin S
*.iopin B
xd D G X B n1_2
xs X G S B n1_2
.ends

* expanding   symbol:  p1_4.sym # of pins=4
** sym_path: /foss/designs/sg13cmos5l_rodovalho_ip__dda/xschem/p1_4.sym
** sch_path: /foss/designs/sg13cmos5l_rodovalho_ip__dda/xschem/p1_4.sch
.subckt p1_4 D G S B
*.iopin D
*.iopin G
*.iopin S
*.iopin B
xs X G S B p1_2
xd D G X B p1_2
.ends

* expanding   symbol:  n1_1.sym # of pins=4
** sym_path: /foss/designs/sg13cmos5l_rodovalho_ip__dda/xschem/n1_1.sym
** sch_path: /foss/designs/sg13cmos5l_rodovalho_ip__dda/xschem/n1_1.sch
.subckt n1_1 D G S B
*.iopin D
*.iopin G
*.iopin S
*.iopin B
**** begin user architecture code

X0 x g s b sg13_hv_nmos W=1.0u L=0.5u ng=1
X1 d g x b sg13_hv_nmos W=1.0u L=0.5u ng=1

**** end user architecture code
.ends

* expanding   symbol:  p4_1.sym # of pins=4
** sym_path: /foss/designs/sg13cmos5l_rodovalho_ip__dda/xschem/p4_1.sym
** sch_path: /foss/designs/sg13cmos5l_rodovalho_ip__dda/xschem/p4_1.sch
.subckt p4_1 D G S B
*.iopin D
*.iopin G
*.iopin S
*.iopin B
xl D G S B p2_1
xr D G S B p2_1
.ends

* expanding   symbol:  n4_1.sym # of pins=4
** sym_path: /foss/designs/sg13cmos5l_rodovalho_ip__dda/xschem/n4_1.sym
** sch_path: /foss/designs/sg13cmos5l_rodovalho_ip__dda/xschem/n4_1.sch
.subckt n4_1 D G S B
*.iopin D
*.iopin G
*.iopin S
*.iopin B
xr D G S B n2_1
xl D G S B n2_1
.ends

* expanding   symbol:  n1_2.sym # of pins=4
** sym_path: /foss/designs/sg13cmos5l_rodovalho_ip__dda/xschem/n1_2.sym
** sch_path: /foss/designs/sg13cmos5l_rodovalho_ip__dda/xschem/n1_2.sch
.subckt n1_2 D G S B
*.iopin D
*.iopin G
*.iopin S
*.iopin B
xd D G X B n1_1
xs X G S B n1_1
.ends

* expanding   symbol:  p1_2.sym # of pins=4
** sym_path: /foss/designs/sg13cmos5l_rodovalho_ip__dda/xschem/p1_2.sym
** sch_path: /foss/designs/sg13cmos5l_rodovalho_ip__dda/xschem/p1_2.sch
.subckt p1_2 D G S B
*.iopin D
*.iopin G
*.iopin S
*.iopin B
xs X G S B p1_1
xd D G X B p1_1
.ends

* expanding   symbol:  p2_1.sym # of pins=4
** sym_path: /foss/designs/sg13cmos5l_rodovalho_ip__dda/xschem/p2_1.sym
** sch_path: /foss/designs/sg13cmos5l_rodovalho_ip__dda/xschem/p2_1.sch
.subckt p2_1 D G S B
*.iopin D
*.iopin G
*.iopin S
*.iopin B
xl D G S B p1_1
xr D G S B p1_1
.ends

* expanding   symbol:  n2_1.sym # of pins=4
** sym_path: /foss/designs/sg13cmos5l_rodovalho_ip__dda/xschem/n2_1.sym
** sch_path: /foss/designs/sg13cmos5l_rodovalho_ip__dda/xschem/n2_1.sch
.subckt n2_1 D G S B
*.iopin D
*.iopin G
*.iopin S
*.iopin B
xr D G S B n1_1
xl D G S B n1_1
.ends

* expanding   symbol:  p1_1.sym # of pins=4
** sym_path: /foss/designs/sg13cmos5l_rodovalho_ip__dda/xschem/p1_1.sym
** sch_path: /foss/designs/sg13cmos5l_rodovalho_ip__dda/xschem/p1_1.sch
.subckt p1_1 D G S B
*.iopin D
*.iopin G
*.iopin S
*.iopin B
**** begin user architecture code

X0 d g s b sg13_hv_pmos W=1.0u L=0.5u ng=1
X1 d g s b sg13_hv_pmos W=1.0u L=0.5u ng=1

**** end user architecture code
.ends

.end
