** sch_path: /home/rodovalho/git/sg13cmos5l_rodovalho_ip__dda/xschem/tb_dda0_open_ac.sch
**.subckt tb_dda0_open_ac
Xdut ip im_ cm cm out avdd avss avss en enb ibias dda0
v_avss GND avss xavss
v_avdd avdd avss dc {xavdd} ac {xavdd_ac}
v_en en avss {xen*xavdd}
v_enb enb avss {(1-xen)*xavdd}
i_ibias avdd ibias {xen*xibias}
c_l out cm {xcl} m=1
c_i im_ im {xci} m=1
l_f out im_ {xlf} m=1
v_cm cm avss {xcm}
v_im im avss dc {xavdd/2}
v_ip ip avss dc {xavdd/2}
**** begin user architecture code

.lib $PDK_ROOT/$PDK/libs.tech/ngspice/models/cornerMOShv.lib mos_tt
.temp 25

.option cshunt=1e-15
.control
  pre_osdi $PDK_ROOT/$PDK/libs.tech/ngspice/osdi/psp103_nqs.osdi

  * differential input
  alter v_ip   ac=0
  alter v_im   ac=1
  alter v_avdd ac=0

  op
  ac dec 100 10m 10G

  * common-mode input
  alter v_ip   ac=1
  alter v_im   ac=1
  alter v_avdd ac=0

  ac dec 100 10m 10G

  * power supply
  alter v_ip   ac=0
  alter v_im   ac=0
  alter v_avdd ac=1

  ac dec 100 10m 10G

  let idd = op.i(v_avdd)
  let av = db(ac1.out)
  let ph = cphase(ac1.out)*180/(4*atan(1))
  let cmrr = db(ac1.out/ac2.out)
  let psrr = db(ac1.out/ac3.out)

  meas ac av0p1hz find av at=0.1
  meas ac gbw when av=0
  meas ac pm180 when ph=-180
  meas ac pm find ph at=gbw
  meas ac gm find av at=pm180

  meas ac cmrr0p1hz find cmrr at=0.1
  meas ac psrr0p1hz find psrr at=0.1

  plot av cmrr psrr
  plot ph
  print idd
.endc

.param xavdd  = 3.3
.param xavss  = 0
.param xcm    = 1.65
.param xvin   = 0
.param xvout  = 0

.param xen =  1
.param xip =  0
.param xim =  1

.param xavdd_ac = 0
.param xvin_ac  = 1
.param xvout_ac = 0

.param xibias = 4u

.param xci    = 1T
.param xri    = 1T
.param xlf    = 1T
.param xrf    = 1f
.param xcl    = 50p
.param xrl    = 5k

**** end user architecture code
**.ends

* expanding   symbol:  dda0.sym # of pins=11
** sym_path: /home/rodovalho/git/sg13cmos5l_rodovalho_ip__dda/xschem/dda0.sym
** sch_path: /home/rodovalho/git/sg13cmos5l_rodovalho_ip__dda/xschem/dda0.sch
.subckt dda0 ipa ima ipb imb o avdd avss vsub en enb ib
*.iopin avdd
*.iopin avss
*.iopin ipa
*.iopin ima
*.iopin o
*.iopin ib
*.iopin vsub
*.iopin en
*.iopin enb
*.iopin ipb
*.iopin imb
Xslice[1] ipa ima ipb imb o avdd avss vsub en enb ib bn yp ym dda0_slice
Xslice[0] ipa ima ipb imb o avdd avss vsub en enb ib bn yp ym dda0_slice
C_yp_avdd avdd yp 4p m=1
C_ym_o o ym 4p m=1
.ends

* expanding   symbol:  dda0_slice.sym # of pins=14
** sym_path: /home/rodovalho/git/sg13cmos5l_rodovalho_ip__dda/xschem/dda0_slice.sym
** sch_path: /home/rodovalho/git/sg13cmos5l_rodovalho_ip__dda/xschem/dda0_slice.sch
.subckt dda0_slice ipa ima ipb imb o avdd avss vsub en enb ib bn yp ym
*.iopin avdd
*.iopin avss
*.iopin ipa
*.iopin ima
*.iopin o
*.iopin ib
*.iopin bn
*.iopin yp
*.iopin ym
*.iopin vsub
*.iopin en
*.iopin enb
*.iopin ipb
*.iopin imb
x10d[1] xna bn avss avss n1_4
x10d[0] xna bn avss avss n1_4
x11d[1] xna bn avss avss n1_4
x11d[0] xna bn avss avss n1_4
x10c[1] yp ima xna avss n1_4
x10c[0] yp ima xna avss n1_4
x11c[1] ym ipa xna avss n1_4
x11c[0] ym ipa xna avss n1_4
x12a[1] yp yp avdd avdd p1_4
x12a[0] yp yp avdd avdd p1_4
x01c[1] bn enb avss avss n1_1
x01c[0] bn enb avss avss n1_1
x01b[1] ib en bn avss n1_1
x01b[0] ib en bn avss n1_1
x00c[1] ib bn avss avss n1_4
x00c[0] ib bn avss avss n1_4
x1[1] yp ym avdd avdd p1_4
x1[0] yp ym avdd avdd p1_4
x2[1] ym ym avdd avdd p1_4
x2[0] ym ym avdd avdd p1_4
x3[1] ym yp avdd avdd p1_4
x3[0] ym yp avdd avdd p1_4
x4[1] xnb bn avss avss n1_4
x4[0] xnb bn avss avss n1_4
x5[1] xnb bn avss avss n1_4
x5[0] xnb bn avss avss n1_4
x6[1] yp imb xnb avss n1_4
x6[0] yp imb xnb avss n1_4
x7[1] ym ipb xnb avss n1_4
x7[0] ym ipb xnb avss n1_4
x8[3] z yp avdd avdd p4_1
x8[2] z yp avdd avdd p4_1
x8[1] z yp avdd avdd p4_1
x8[0] z yp avdd avdd p4_1
x9[3] o ym avdd avdd p4_1
x9[2] o ym avdd avdd p4_1
x9[1] o ym avdd avdd p4_1
x9[0] o ym avdd avdd p4_1
x10[3] z z avss avss n4_1
x10[2] z z avss avss n4_1
x10[1] z z avss avss n4_1
x10[0] z z avss avss n4_1
x11[3] o z avss avss n4_1
x11[2] o z avss avss n4_1
x11[1] o z avss avss n4_1
x11[0] o z avss avss n4_1
.ends

* expanding   symbol:  n1_4.sym # of pins=4
** sym_path: /home/rodovalho/git/sg13cmos5l_rodovalho_ip__dda/xschem/n1_4.sym
** sch_path: /home/rodovalho/git/sg13cmos5l_rodovalho_ip__dda/xschem/n1_4.sch
.subckt n1_4 D G S B
*.iopin D
*.iopin G
*.iopin S
*.iopin B
xd D G X B n1_2
xs X G S B n1_2
.ends

* expanding   symbol:  p1_4.sym # of pins=4
** sym_path: /home/rodovalho/git/sg13cmos5l_rodovalho_ip__dda/xschem/p1_4.sym
** sch_path: /home/rodovalho/git/sg13cmos5l_rodovalho_ip__dda/xschem/p1_4.sch
.subckt p1_4 D G S B
*.iopin D
*.iopin G
*.iopin S
*.iopin B
xs X G S B p1_2
xd D G X B p1_2
.ends

* expanding   symbol:  n1_1.sym # of pins=4
** sym_path: /home/rodovalho/git/sg13cmos5l_rodovalho_ip__dda/xschem/n1_1.sym
** sch_path: /home/rodovalho/git/sg13cmos5l_rodovalho_ip__dda/xschem/n1_1.sch
.subckt n1_1 D G S B
*.iopin D
*.iopin G
*.iopin S
*.iopin B
**** begin user architecture code

X0 x g s b sg13_hv_nmos W=1.0u L=0.5u ng=1 m=1
X1 d g x b sg13_hv_nmos W=1.0u L=0.5u ng=1 m=1

**** end user architecture code
.ends

* expanding   symbol:  p4_1.sym # of pins=4
** sym_path: /home/rodovalho/git/sg13cmos5l_rodovalho_ip__dda/xschem/p4_1.sym
** sch_path: /home/rodovalho/git/sg13cmos5l_rodovalho_ip__dda/xschem/p4_1.sch
.subckt p4_1 D G S B
*.iopin D
*.iopin G
*.iopin S
*.iopin B
xl D G S B p2_1
xr D G S B p2_1
.ends

* expanding   symbol:  n4_1.sym # of pins=4
** sym_path: /home/rodovalho/git/sg13cmos5l_rodovalho_ip__dda/xschem/n4_1.sym
** sch_path: /home/rodovalho/git/sg13cmos5l_rodovalho_ip__dda/xschem/n4_1.sch
.subckt n4_1 D G S B
*.iopin D
*.iopin G
*.iopin S
*.iopin B
xr D G S B n2_1
xl D G S B n2_1
.ends

* expanding   symbol:  n1_2.sym # of pins=4
** sym_path: /home/rodovalho/git/sg13cmos5l_rodovalho_ip__dda/xschem/n1_2.sym
** sch_path: /home/rodovalho/git/sg13cmos5l_rodovalho_ip__dda/xschem/n1_2.sch
.subckt n1_2 D G S B
*.iopin D
*.iopin G
*.iopin S
*.iopin B
xd D G X B n1_1
xs X G S B n1_1
.ends

* expanding   symbol:  p1_2.sym # of pins=4
** sym_path: /home/rodovalho/git/sg13cmos5l_rodovalho_ip__dda/xschem/p1_2.sym
** sch_path: /home/rodovalho/git/sg13cmos5l_rodovalho_ip__dda/xschem/p1_2.sch
.subckt p1_2 D G S B
*.iopin D
*.iopin G
*.iopin S
*.iopin B
xs X G S B p1_1
xd D G X B p1_1
.ends

* expanding   symbol:  p2_1.sym # of pins=4
** sym_path: /home/rodovalho/git/sg13cmos5l_rodovalho_ip__dda/xschem/p2_1.sym
** sch_path: /home/rodovalho/git/sg13cmos5l_rodovalho_ip__dda/xschem/p2_1.sch
.subckt p2_1 D G S B
*.iopin D
*.iopin G
*.iopin S
*.iopin B
xl D G S B p1_1
xr D G S B p1_1
.ends

* expanding   symbol:  n2_1.sym # of pins=4
** sym_path: /home/rodovalho/git/sg13cmos5l_rodovalho_ip__dda/xschem/n2_1.sym
** sch_path: /home/rodovalho/git/sg13cmos5l_rodovalho_ip__dda/xschem/n2_1.sch
.subckt n2_1 D G S B
*.iopin D
*.iopin G
*.iopin S
*.iopin B
xr D G S B n1_1
xl D G S B n1_1
.ends

* expanding   symbol:  p1_1.sym # of pins=4
** sym_path: /home/rodovalho/git/sg13cmos5l_rodovalho_ip__dda/xschem/p1_1.sym
** sch_path: /home/rodovalho/git/sg13cmos5l_rodovalho_ip__dda/xschem/p1_1.sch
.subckt p1_1 D G S B
*.iopin D
*.iopin G
*.iopin S
*.iopin B
**** begin user architecture code

X0 d g s b sg13_hv_pmos W=1.0u L=0.5u ng=1 m=1
X1 d g s b sg13_hv_pmos W=1.0u L=0.5u ng=1 m=1

**** end user architecture code
.ends

.GLOBAL GND
.end
